* Behavioral device models for the sim leg.
*
* These are intentionally idealised (fast, well-behaved) so transient sims of
* oscillators converge cleanly. They capture the behaviour the sim needs to
* answer "does it oscillate, and how does it track CV" -- not vendor-exact
* distortion/noise. The real PCB uses the actual ICs.
*
* IC subckts list their nodes in DIP pin order (1..N), so the netlister can
* emit `X<ref> <net@pad1> <net@pad2> ... <subckt>` straight from pad numbers.

* --- primitive op-amp: high gain, ~100kHz dominant pole, rail clamp ---
.subckt opamp inp inn out vcc vee
Bg ng 0 V = 1e5*(V(inp)-V(inn))
Rg ng n1 1k
Cp n1 0 1.59n
Bo out 0 V = max(V(vee)+1.5, min(V(vcc)-1.5, V(n1)))
.ends

* --- primitive OTA (LM13700 transconductor): Iout = Iabc * tanh(Vd/2Vt) ---
* iabc pin sits ~1.4V above V- (two junction drops); external R sets Iabc.
.subckt ota_core inp inn iabc out vcc vee
Bclamp nx 0 V = V(vee)+1.4
Vsense iabc nx 0
Bout 0 out I = I(Vsense) * tanh( (V(inp)-V(inn)) / 0.052 )
.ends

* ====================================================================
* TL072 dual op-amp (DIP-8)
*   1 OUT1  2 IN1-  3 IN1+  4 V-  5 IN2+  6 IN2-  7 OUT2  8 V+
* ====================================================================
.subckt tl072 1 2 3 4 5 6 7 8
Xa 3 2 1 8 4 opamp
Xb 5 6 7 8 4 opamp
.ends

* ====================================================================
* LM13700 dual OTA + buffers (DIP-16)
*   1 IABC1  2 DIODE1  3 +IN1  4 -IN1  5 OUT1  6 BUFIN1  7 BUFOUT1  8 V-
*   9 BUFOUT2 10 BUFIN2 11 OUT2 12 -IN2 13 +IN2 14 DIODE2 15 IABC2 16 V+
* Buffers modelled as unity followers; unused inputs tied off to avoid
* floating nodes.
* ====================================================================
* Unconnected pins are tied off to 0 by the netlister, so the buffers and the
* unused second OTA settle cleanly without floating nodes.
.subckt lm13700 1 2 3 4 5 6 7 8 9 10 11 12 13 14 15 16
Xota1 3 4 1 5 16 8 ota_core
Xota2 13 12 15 11 16 8 ota_core
* Darlington buffers: unity-gain followers (BUFIN -> BUFOUT)
Bbuf1 7 0 V = V(6)
Bbuf2 9 0 V = V(10)
.ends
